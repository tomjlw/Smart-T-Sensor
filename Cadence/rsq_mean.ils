/* abBestFit.ils

Author     A.D.Beckett
Group      Custom IC (UK), Cadence Design Systems Ltd.
Language   SKILL
Date       Apr 05, 2018
Modified
By

Compute a best fit line for an input waveform. Uses
Simple Linear Regression to compute the slope and intercept
and then constructs a waveform with this slope and intercept

Two functions:

abBestFit(waveform) - returns a best fit waveform

abBestFitCoeffs(waveform) - returns a list of the intercept and slope

Note, this uses SKILL++ lexical scoping so must keep the .ils
suffix

From IC618 ISR1 can now be added to the calculator via the fx button
(also in the expression builder via the + button)

***************************************************

SCCS Info: @(#) abBestFit.ils 06/11/20.12:22:29 1.3

*/

(let ()
  /***************************************************************
  *                                                              *
  *                        (mean vector)                         *
  *                                                              *
  *     Internal function to compute the mean of the values      *
  *                        in the vector                         *
  *                                                              *
  ***************************************************************/
  (defun mean (vector)
    (let ((n (drVectorLength vector)) (sum 0.0))
      (for i 0 (sub1 n)
           (setq sum (plus sum (drGetElem vector i))))
      (quotient sum (if (zerop n) 1 n))
      )
    )
  /***************************************************************
  *                                                              *
  *            (sum of squares of total for vector)              *
  *                                                              *
  * Internal function to compute sum of squares of total         *
  *  of vector. Pass in vectors and get numerical values         *
  *                                                              *
  *                                                              *
  ***************************************************************/
  (defun tss (vector)
    (let ((n (drVectorLength vector)) (tmpsum 0.0) vmean)
	  (setq vmean (mean vector))
      (for i 0 (sub1 n)
           (setq tmpsum
                 (plus tmpsum
                       (expt
                         (difference (drGetElem vector i) vmean)
                         2))))
      (quotient tmpsum 1)
      )
    )
  /***************************************************************
  *                                                              *
  *            (uncorrectedStddev vector vectorMean)             *
  *                                                              *
  * Internal function to compute uncorrected standard deviation  *
  *  of vector. Same as population standard deviation. Pass in   *
  *   vector and mean so don't have to compute the mean again    *
  *                                                              *
  ***************************************************************/
  (defun uncorrectedStddev (vector vectorMean)
    (let ((n (drVectorLength vector)) (sum 0.0))
      (for i 0 (sub1 n)
           (setq sum
                 (plus sum
                       (expt
                         (difference (drGetElem vector i) vectorMean)
                         2))))
      (sqrt (quotient sum (if (zerop n) 1 n)))
      )
    )
  /*****************************************************************
  *                                                                *
  *            (sampleCorrCoeff xVec yVec xMean yMean)             *
  *                                                                *
  * Internal function to compute the sample correlation coefficent *
  *                  between the x and y vectors                   *
  *                                                                *
  *****************************************************************/
  (defun sampleCorrCoeff (xVec yVec xMean yMean)
    (let (xSquared ySquared xy xyMean xSquaredMean ySquaredMean)
      (setq xy (times xVec yVec))
      (setq xSquared (expt xVec 2.0))
      (setq ySquared (expt yVec 2.0))
      (setq xyMean (mean xy))
      (setq xSquaredMean (mean xSquared))
      (setq ySquaredMean (mean ySquared))
      (quotient
        (difference xyMean (times xMean yMean))
        (sqrt
          (times
            (difference xSquaredMean (expt xMean 2.0))
            (difference ySquaredMean (expt yMean 2.0))
            )))
      ))
  /***************************************************************
  *                                                              *
  *                  (computeCoeffs xVec yVec)                   *
  *                                                              *
  *  Internal function to compute the alpha and beta - intercept *
  *             and slope - from the x and y vectors             *
  *                                                              *
  ***************************************************************/
  (defun computeCoeffs (xVec yVec)
    (let (xMean yMean xStddev yStddev rxy alpha beta)
      (setq xMean (mean xVec))
      (setq yMean (mean yVec))
      (setq xStddev (uncorrectedStddev xVec xMean))
      (setq yStddev (uncorrectedStddev yVec yMean))
      (setq rxy (sampleCorrCoeff xVec yVec xMean yMean))
      (setq beta (times rxy (quotient yStddev xStddev)))
      (setq alpha (difference yMean (times beta xMean)))
      (list alpha beta)
      )
    )
  /***************************************************************
  *                                                              *
  *                    (abBestFitCoeffs wave)                    *
  *                                                              *
  *  Global function to compute alpha and beta - intercept and   *
  *          slope of the best fit line and return them          *
  *                                                              *
  ***************************************************************/
  (defglobalfun abBestFitCoeffs (wave)
    (let (xVec yVec)
      (setq xVec (drGetWaveformXVec wave))
      (setq yVec (drGetWaveformYVec wave))
      (when (eq (drGetWaveformYType wave) 'doublecomplex)
        (error "abBestFitCoeffs: Cannot handle waveforms with complex values; use mag() or db20() or similar to convert to double values")
        )
      (computeCoeffs xVec yVec)
      )
    )
  /***************************************************************
  *                                                              *
  *                       (abBestFit wave)                       *
  *                                                              *
  *           Compute the slope and intercept and then           *
  *  create a waveform (with two points) matching the first and  *
  *             last x points of the input waveform              *
  *                                                              *
  ***************************************************************/
  (defglobalfun rsq_mean (wave)
    (cond
      ((drIsWaveform wave)
       (let (rawxVec rawyVec xVec yVec len firstX lastX newXVec newYVec newWave nsum rss rsq tmppsum ncorner rsq_mean)
         ;---------------------------------------------------------------
         ; Compute slope and intercept of best fit line
         ;---------------------------------------------------------------
		(setq ncorner 5)
         (setq rawxVec (drGetWaveformXVec wave))
         (setq rawyVec (drGetWaveformYVec wave))
         (when (eq (drGetWaveformYType wave) 'doublecomplex)
           (error "rsq: Cannot handle waveforms with complex values; use mag() or db20() or similar to convert to double values")
           )
		 (setq tmppsum 0.0)
		 (for j 0 (sub1 ncorner)
		 (setq xVec (drCreateVec 'double (quotient (drVectorLength rawxVec) ncorner)))
		 (setq yVec (drCreateVec 'double (quotient (drVectorLength rawyVec) ncorner)))
		 (for k 0 (sub1 (quotient (drVectorLength rawxVec) ncorner))
		 (drAddElem xVec (drGetElem rawxVec (plus (times j (quotient (drVectorLength rawxVec) ncorner)) k)))
          (drAddElem yVec (drGetElem rawyVec (plus (times j (quotient (drVectorLength rawyVec) ncorner)) k)))
          )

         (destructuringBind (alpha beta) (computeCoeffs xVec yVec)

           ;-------------------------------------------------------------
           ; Construct best fit line waveform
           ;-------------------------------------------------------------
           (setq len (drVectorLength xVec))
           (setq firstX (drGetElem xVec 0))
           (setq lastX (drGetElem xVec (sub1 len)))
           (setq newXVec (drCreateVec 'double 2))
           (setq newYVec (drCreateVec 'double 2))
           (drAddElem newXVec firstX)
           (drAddElem newXVec lastX)
           (drAddElem newYVec (plus alpha (times beta firstX)))
           (drAddElem newYVec (plus alpha (times beta lastX)))
           ;-------------------------------------------------------------
           ; Sort out attributes for new waveform to match input
           ;-------------------------------------------------------------
           (putpropq newXVec (getq xVec units) units)
           (putpropq newXVec (getq xVec name) name)
           (putpropq newYVec (getq yVec units) units)
           (putpropq newYVec (getq yVec name) name)
           (setq newWave (drCreateWaveform newXVec newYVec))

		   (setq nsum 0.0)

		   (for i 0 (sub1 len)
			(
				setq nsum (plus nsum (expt (difference (drGetElem yVec i) (plus alpha (times beta (drGetElem xVec i)))) 2))
			  )
			)
		   (setq rss nsum)
		   (setq rsq (difference 1 (quotient rss (tss yVec))))
		   (setq tmppsum (plus tmppsum rsq)))
)
(setq rsq_mean (quotient tmppsum ncorner))

           (famSetExpr newWave `(rsq_mean ,(famGetExpr wave)))
           rsq_mean

         )
       )
      ((famIsFamily wave)
       (famMap 'rsq_mean wave)
       )
      (t
        (error "abBestFit: cannot handle %L\n" wave)
        )
      )
    )
  )

;
;;;;;;;;;;;;;;;;;;;;;;;;;; GUI builder information ;;;;;;;;;;;;;;;;;;;;;;;;;;;
ocnmRegGUIBuilder(
 '(nil
  function rsq_mean
  name rsq_mean
  description "mean R2 value across 5 corners for linear regression(used for optimization)"
  category ("Custom Functions")
  analysis (nil
      general (nil
        args (wave )
          signals (nil
                wave (nil
                      prompt "Signal"
                      tooltip "Waveform"
                      )
           )
          params(nil
          )
        inputrange t
      )
  )
  outputs(result)
 )
)
